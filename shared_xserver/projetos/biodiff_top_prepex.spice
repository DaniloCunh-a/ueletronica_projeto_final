* NGSPICE file created from biodiff_top.ext - technology: ihp-sg13g2

.subckt biodiff_top VIN_N VIN_P VOUT_N VOUT_P VDD TAIL VSS
X0 a_1920_2000# VIN_N TAIL VSS sg13_lv_nmos ad=28.8p pd=28.8u as=33.6p ps=29.6u w=12u l=0.8u
X1 TAIL VIN_P a_3600_2000# VSS sg13_lv_nmos ad=28.8p pd=28.8u as=33.6p ps=29.6u w=12u l=0.8u
C0 a_1920_2000# TAIL 0.34521f
C1 a_1920_2000# VIN_N 0.17393f
C2 a_1920_2000# a_2000_6000# 0.02593f
C3 VIN_P TAIL 0.14993f
C4 a_2000_6000# a_3600_6000# 0.0196f
C5 a_2000_6000# VDD 0.03856f
C6 a_1920_2000# a_3600_2000# 0.04203f
C7 a_3600_2000# a_3600_6000# 0.02593f
C8 VIN_N TAIL 0.14993f
C9 a_3600_2000# VIN_P 0.12504f
C10 VDD a_3600_6000# 0.03856f
C11 a_3600_2000# TAIL 0.39541f
C12 TAIL VSS 1.21104f
C13 VIN_P VSS 2.11003f
C14 VIN_N VSS 2.08779f
C15 VDD VSS 2.71857f
C16 a_3600_2000# VSS 1.07468f
C17 a_1920_2000# VSS 1.04984f
C18 a_3600_6000# VSS 2.66589f $ **FLOATING
C19 a_2000_6000# VSS 2.66589f $ **FLOATING
.ends
