* NGSPICE file created from biodiff_top.ext - technology: ihp-sg13g2

.subckt biodiff_top VIN_N VIN_P VOUT_N VOUT_P VDD TAIL VSS
X0 TAIL VIN_P VOUT_P VSS sg13_lv_nmos ad=0.64p pd=3.2u as=0.64p ps=3.2u w=3.2u l=0.8u
X1 VOUT_N VIN_N TAIL VSS sg13_lv_nmos ad=0.64p pd=3.2u as=0.64p ps=3.2u w=3.2u l=0.8u
C0 a_2000_6000# a_3600_6000# 0.0196f
C1 a_2000_6000# VOUT_P 0
C2 TAIL VIN_P 0.97369f
C3 VOUT_N VDD 0.00457f
C4 a_3600_6000# VDD 0.08002f
C5 VOUT_P VDD 0.00457f
C6 VIN_N VOUT_N 0.51703f
C7 VOUT_N a_3600_6000# 0
C8 VOUT_P VOUT_N 0.01035f
C9 VOUT_P VIN_N 0
C10 VOUT_P a_3600_6000# 0.07299f
C11 TAIL VOUT_N 0.00445f
C12 TAIL VIN_N 0.97369f
C13 a_2000_6000# VDD 0.08002f
C14 VOUT_N VIN_P 0
C15 TAIL VOUT_P 0.00445f
C16 VIN_N VIN_P 0.02352f
C17 VOUT_P VIN_P 0.39328f
C18 a_2000_6000# VOUT_N 0.07299f
C19 TAIL VSS 1.09218f
C20 VIN_P VSS 8.95348f
C21 VIN_N VSS 8.92445f
C22 VOUT_P VSS 1.10596f
C23 VOUT_N VSS 1.07562f
C24 VDD VSS 2.71339f
C25 a_3600_6000# VSS 2.4319f $ **FLOATING
C26 a_2000_6000# VSS 2.4319f $ **FLOATING
.ends
