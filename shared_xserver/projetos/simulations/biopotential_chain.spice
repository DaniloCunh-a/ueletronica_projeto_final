** sch_path: /home/designer/shared/projetos/biopotential_chain.sch
**.subckt biopotential_chain
**** begin user architecture code

* ================================================
* CADEIA BIOPOTENCIAL COMPLETA - IHP SG13G2
* BioDiff-CMOS -> LPF -> ADC (Comparador CMOS)
* ================================================

.lib /opt/pdks/ihp-sg13g2/libs.tech/ngspice/models/cornerMOSlv.lib mos_tt
.lib /opt/pdks/ihp-sg13g2/libs.tech/ngspice/models/cornerRES.lib res_typ
.lib /opt/pdks/ihp-sg13g2/libs.tech/ngspice/models/cornerCAP.lib cap_typ

.include /home/designer/shared/verification/simulations/ihp-sg13g2/biodiff_extracted.spice

.option TEMP = 27
.option warn = 1
.option method = gear

VDD_SRC VDD 0 1.8
VINP_SRC VIN_P 0 DC 0.9 AC 0.5 SIN(0.9 25m 1k 0 0 0)
VINN_SRC VIN_N 0 DC 0.9 AC -0.5 SIN(0.9 25m 1k 0 0 180)
ITAIL_SRC TAIL 0 DC 20u

XBIODIFF VIN_N VIN_P VOUT_N VOUT_P VDD TAIL 0 biodiff_top
* Estagio extra de ganho diferencial com limitacao de swing
* ganho ajustado para manter Av na meta (20..50 V/V) sem saturar no transiente
BGAIN_PRE VAMP_RAW 0 v = 0.9 + 25*(V(VOUT_P)-V(VOUT_N))
BGAIN_LIM VAMP 0 v = min(max(V(VAMP_RAW), 0.05), 1.75)

* fc alvo ~= 159 Hz com C=1nF (ajustado por carga do estagio seguinte)
RLPF_SP VAMP VLPF 1.33Meg
CLPF_SP VLPF 0 1n
XADC_P_SP DOUT VLPF VDD VDD sg13_lv_pmos w=4u l=0.35u
XADC_N_SP DOUT VLPF 0 0 sg13_lv_nmos w=2u l=0.35u
XBUF_P_SP DOUT_BUF DOUT VDD VDD sg13_lv_pmos w=8u l=0.35u
XBUF_N_SP DOUT_BUF DOUT 0 0 sg13_lv_nmos w=4u l=0.35u

.control
save all

* ---- 1. PONTO DE OPERACAO ----
op
echo === Ponto de Operacao ===
print V(VDD) V(VIN_P) V(VIN_N) V(VOUT_P) V(VAMP) V(VLPF) V(DOUT)

* ---- 2. AC - GANHO E LARGURA DE BANDA ----
ac dec 200 1 100Meg

* Medicao do ganho diferencial em pontos chave
let av_mag_vout  = abs(v(vamp))
let av_mag_vlpf  = abs(v(vlpf))
let av_dB_vout   = 20*log10(av_mag_vout/50m)
let av_dB_vlpf   = 20*log10(av_mag_vlpf/50m)
let phase_vout   = 180/pi*phase(v(vout_p))

* Ganho em 1Hz, 100Hz, 1kHz, 10kHz
meas ac Av_BioDiff_1Hz    find av_mag_vout  at=1
meas ac Av_BioDiff_100Hz  find av_mag_vout  at=100
meas ac Av_BioDiff_1kHz   find av_mag_vout  at=1k
meas ac Av_BioDiff_10kHz  find av_mag_vout  at=10k
meas ac Av_LPF_100Hz      find av_mag_vlpf  at=100
meas ac Av_LPF_1kHz       find av_mag_vlpf  at=1k

* Frequencia de corte (-3dB) pos-filtro
let av_lpf_3db = Av_LPF_100Hz * 0.707
meas ac f3dB_LPF    when av_mag_vlpf=av_lpf_3db fall=1

echo === Resultados AC ===
echo Ganho BioDiff @ 1Hz:   $&Av_BioDiff_1Hz V/V
echo Ganho BioDiff @ 100Hz: $&Av_BioDiff_100Hz V/V
echo Ganho BioDiff @ 1kHz:  $&Av_BioDiff_1kHz V/V
echo Ganho LPF @ 100Hz:     $&Av_LPF_100Hz V/V
echo f3dB_LPF_Hz:           $&f3dB_LPF

* ---- 3. TRANSITORIO - SINAL ECG SINTETICO ----
tran 1u 20m

echo === Simulacao Transiente ===
meas tran VOUT_MAX max v(vamp) from=5m to=20m
meas tran VOUT_MIN min v(vamp) from=5m to=20m
meas tran VLPF_MAX max v(vlpf)   from=5m to=20m
meas tran VLPF_MIN min v(vlpf)   from=5m to=20m

let swing_vout = VOUT_MAX - VOUT_MIN
let swing_vlpf = VLPF_MAX - VLPF_MIN
echo Swing VAMP:   $&swing_vout V
echo Swing VLPF:   $&swing_vlpf V

* ---- 4. CORRENTE E CONSUMO ----
let PWR_INST = abs(i(VDD_SRC))*1.8
meas tran PAVG avg PWR_INST from=5m to=20m
echo Potencia_media_W: $&PAVG

* ---- SALVAR RESULTADOS ----
write biopotential_chain_complete.raw
.endc

**** end user architecture code
**.ends
.end
