* NGSPICE file created from biodiff_top.ext - technology: ihp-sg13g2

.subckt biodiff_top VIN_N VIN_P VOUT_N VOUT_P VDD TAIL VSS
X0 TAIL VIN_P VOUT_P VSS sg13_lv_nmos ad=0.64p pd=3.2u as=0.64p ps=3.2u w=3.2u l=0.8u
X1 VOUT_N VIN_N TAIL VSS sg13_lv_nmos ad=0.64p pd=3.2u as=0.64p ps=3.2u w=3.2u l=0.8u
C0 VIN_N VOUT_N 0.6037f
C1 VOUT_P VOUT_N 0.01249f
C2 VIN_P TAIL 0.97369f
C3 VIN_N TAIL 0.97369f
C4 VOUT_P TAIL 0.00445f
C5 VIN_P VIN_N 0.02352f
C6 VOUT_P VDD 0.00642f
C7 VIN_P VOUT_P 0.47867f
C8 VOUT_N TAIL 0.00445f
C9 VOUT_N VDD 0.00642f
C10 VIN_P VOUT_N 0
C11 VOUT_P VIN_N 0
C12 TAIL VSS 1.09218f
C13 VIN_P VSS 8.92562f
C14 VIN_N VSS 8.89656f
C15 VOUT_P VSS 1.24422f
C16 VOUT_N VSS 1.21388f
C17 VDD VSS 3.10029f
XLOAD_N VDD VOUT_N VSS rhigh l=10u w=2u
XLOAD_P VDD VOUT_P VSS rhigh l=10u w=2u
.ends
