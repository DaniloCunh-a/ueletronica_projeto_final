* BioDiff-CMOS post-layout template (IHP SG13G2)
* Usage:
* 1) Copy your extracted netlist to this folder as: biodiff_extracted.spice
* 2) Adjust xdut pin order and subckt name to match your extracted file
* 3) Run:
*    cd /home/designer/shared/verification/simulations
*    PDK=ihp-sg13g2 make TOP=ihp-sg13g2/biodiff_postlayout_template.spice sim

.option TEMP=27
.option warn=1

* Common-mode and differential input stimulus
* 100 mVpp differential (50 mV amplitude each side around 0.9 V common-mode)
VINP vinp 0 DC 0.9 AC 0.5 SIN(0.9 0.05 1k)
VINN vinn 0 DC 0.9 AC -0.5 SIN(0.9 0.05 1k 0 0 180)

* Bias source example (adjust/remove if not needed by your circuit)
* IBIAS ibias 0 DC 10u

* DUT instance
* Replace with your extracted subckt name and pin order.
* Example:
* xdut vinn vinp vout 0 biodiff_top
xdut vinn vinp vout 0 biodiff_top

* Include extracted post-layout netlist.
* You are running ngspice from /home/designer/shared/verification/simulations,
* so the path must be relative to that directory.
.include ./ihp-sg13g2/biodiff_extracted.spice

* IHP SG13G2 model libraries
.lib /opt/pdks/ihp-sg13g2/libs.tech/ngspice/models/cornerMOSlv.lib mos_tt
.lib /opt/pdks/ihp-sg13g2/libs.tech/ngspice/models/cornerRES.lib res_typ
.lib /opt/pdks/ihp-sg13g2/libs.tech/ngspice/models/cornerCAP.lib cap_typ

.control
pre_osdi /opt/pdks/ihp-sg13g2/libs.tech/ngspice/osdi/psp103.osdi
pre_osdi /opt/pdks/ihp-sg13g2/libs.tech/ngspice/osdi/psp103_nqs.osdi
pre_osdi /opt/pdks/ihp-sg13g2/libs.tech/ngspice/osdi/mosvar.osdi

* Operating point check
op

* Frequency response: estimate gain and -3 dB point
ac dec 100 1 100Meg
let av_mag = abs(v(vout))
meas ac av_1k   find av_mag at=1k
meas ac av_10k  find av_mag at=10k

* Time-domain waveform
tran 10u 10m

* Export results
wrdata biodiff_vout_tran.data v(vout)
.endc

.end
